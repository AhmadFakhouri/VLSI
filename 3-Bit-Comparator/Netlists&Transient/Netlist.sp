. SUBCKT anda A2 B2 COMP OUT-AND Y2 Gnd Vdd
M1 Y2 A2 N7 Gnd NMOS L=0.5u W=5u AD=66p PD=24u AS=66p PS=24u
M2 N7 B2 COMP N11 Gnd NMOS L=0.5u W=5u AD=66p PD=24u AS=66p PS=24u
M3 N11 OUT-AND Gnd Gnd NMOS L=0.5u W=5u AD=66p PD=24u AS=66p PS=24u
M4 Y2 B2 COMP Vdd Vdd PMOS L=0.5u W=10u AD=66p PD=24u AS=66p PS=24u
M5 Y2 A2 Vdd Vdd PMOS L=0.5u W=10u AD=66p PD=24u AS=66p PS=24u
M6 Y2 OUT-AND Vdd Vdd PMOS L=0.5u W=10u AD=66p PD=24u AS=66p PS=24u
. ENDS

. SUBCKT INVERTER INV_OUT X Gnd Vdd
M1 INV_OUT X Gnd Gnd NMOS L=2u W=22u AD=66p PD=24u AS=66p PS=24u
M2 INV OUT X Vdd Vdd PMOS L=2u W=22u AD=66p PD=24u AS=66p PS=24u
. ENDS

.SUBCKT Module0 A3 B3-COMP Y3 Gnd Vdd
M1 N11 B3-COMP Gnd Gnd NMOS L=0.5u W=22u AD=66p PD=24u AS=66p PS=24u
M2 Y3 A3 N11 Gnd NMOS L=0.5u W=22u AD=66p PD=24u AS=66p PS=24u
M3 Y3 A3 Vdd Vdd PMOS L=0.5u W=22u AD=66p PD=24u AS=66p PS=24u
M4 Y3 B3-COMP Vdd Vdd PMOS L=0.5u W=22u AD=66p PD=24u AS=66p PS=24u
. ENDS

. SUBCKT NOR A B C Y Gnd Vdd
M1 Y C Gnd Gnd NMOS L=0.5u W=1u AD=66p PD=24u AS=66p PS=24u
M2 Y B Gnd Gnd NMOS L=0.5u W=1u AD=66p PD=24u AS=66p PS=24u
M3 Y A Gnd Gnd NMOS L=0.5u W=1u AD=66p PD=24u AS=66p PS=24u
M4 N17 A Vdd Vdd PMOS L=0.5u W=20u AD=66p PD=24u AS=66p PS=24u
M5 N21 B N17 Vdd PMOS L=0.5u W=20u AD=66p PD=24u AS=66p PS=24u
M6 Y C N21 Vdd PMOS L=0.5u W=20u AD=66p PD=24u AS=66p PS=24u
. ENDS
Main Circuit: FINAL-SCH
Xanda 1 N4 B1 N18 N20 Gnd Vdd anda
Xanda 2 A2 N1 N11 N18 Gnd Vdd anda
Xanda 3 A1 N8 N14 N9 Gnd Vdd anda
Xanda 5 N3 B2 N12 N14 Gnd Vdd anda
XINVERTER 1 N19 N12 Gnd Vdd INVERTER
XINVERTER 2 N5 B3 Gnd Vdd INVERTER
XINVERTER 3 N1 B2 Gnd Vdd INVERTER
XTNVERTER 4 N8 B1 Gnd Vdd TNVERTER
XINVERTER 5 N2 N18 Gnd Vdd INVERTER
XINVERTER 6 N15 A3 Gnd Vdd INVERTER
XINVERTER 7 N3 A2 Gnd Vdd INVERTER
XINVERTER 8 N7 N9 Gnd Vdd INVERTER
XINVERTER 9 N16 N20 Gnd Vdd INVERTER
XINVERTER 10 N17 N11 Gnd Vdd INVERTER
XINVERTER 11 N21 N14 Gnd Vdd INVERTER
XINVERTER 12 A-BIGGER N10 Gnd Vdd INVERTER
XINVERTER 13 B-BIGGER N13 Gnd Vdd INVERTER
XINVERTER 15 N4 A1 Gnd Vdd INVERTER
XModule0 1 B3 N15 N11 Gnd Vdd Module0
XModule0 2 N5 A3 N12 Gnd Vdd Module0
XNOR 1 N7 N2 N19 N10 Gnd Vdd NOR
XNOR 2 N16 N21 N17 N13 Gnd Vdd NOR
* End of main circuit: FINAL-SCH
